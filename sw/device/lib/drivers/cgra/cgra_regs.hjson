// Copyright EPFL contributors.
// Licensed under the Apache License, Version 2.0, see LICENSE for details.
// SPDX-License-Identifier: Apache-2.0

{ name: "cgra",
  clock_primary: "clk_i",
  bus_interfaces: [
    { protocol: "reg_iface", direction: "device" }
  ],
  regwidth: "32",
  registers: [
    { name:     "COL_STATUS",
      desc:     "CGRA columns status",
      swaccess: "rw",
      hwaccess: "hro",
      fields: [
        { bits: "31:0", name: "COL_STATUS", desc: "CGRA columns status" }
      ]
    },
    { name:     "SLOT0_KER_ID",
      desc:     "Slot 0 kernel ID",
      swaccess: "rw",
      hwaccess: "hro",
      fields: [
        { bits: "31:0", name: "SLOT0_KER_ID", desc: "Slot 0 kernel ID" }
      ]
    },
    { name:     "SLOT1_KER_ID",
      desc:     "Slot 1 kernel ID",
      swaccess: "rw",
      hwaccess: "hro",
      fields: [
        { bits: "31:0", name: "SLOT1_KER_ID", desc: "Slot 1 kernel ID" }
      ]
    },
    { name:     "SLOT0_PTR_IN_C0",
      desc:     "Slot 0 input data pointer for first column used",
      swaccess: "rw",
      hwaccess: "hro",
      fields: [
        { bits: "31:0", name: "SLOT0_PTR_IN_C0", desc: "Slot 0 input data pointer for first column used" }
      ]
    },
    { name:     "SLOT0_PTR_OUT_C0",
      desc:     "Slot 0 output data pointer for first column used",
      swaccess: "rw",
      hwaccess: "hro",
      fields: [
        { bits: "31:0", name: "SLOT0_PTR_OUT_C0", desc: "Slot 0 output data pointer for first column used" }
      ]
    },
    { name:     "SLOT0_PTR_IN_C1",
      desc:     "Slot 0 input data pointer for second column used",
      swaccess: "rw",
      hwaccess: "hro",
      fields: [
        { bits: "31:0", name: "SLOT0_PTR_IN_C1", desc: "Slot 0 input data pointer for second column used" }
      ]
    },
    { name:     "SLOT0_PTR_OUT_C1",
      desc:     "Slot 0 Output data pointer for second column used",
      swaccess: "rw",
      hwaccess: "hro",
      fields: [
        { bits: "31:0", name: "SLOT0_PTR_OUT_C1", desc: "Slot 0 Output data pointer for second column used" }
      ]
    },
    { name:     "SLOT0_PTR_IN_C2",
      desc:     "Slot 0 input data pointer for third column used",
      swaccess: "rw",
      hwaccess: "hro",
      fields: [
        { bits: "31:0", name: "SLOT0_PTR_IN_C2", desc: "Slot 0 input data pointer for third column used" }
      ]
    },
    { name:     "SLOT0_PTR_OUT_C2",
      desc:     "Slot 0 output data pointer for first column used",
      swaccess: "rw",
      hwaccess: "hro",
      fields: [
        { bits: "31:0", name: "SLOT0_PTR_OUT_C2", desc: "Slot 0 output data pointer for first column used" }
      ]
    },
    { name:     "SLOT0_PTR_IN_C3",
      desc:     "Slot 0 input data pointer for fourth column used",
      swaccess: "rw",
      hwaccess: "hro",
      fields: [
        { bits: "31:0", name: "SLOT0_PTR_IN_C3", desc: "Slot 0 input data pointer for fourth column used" }
      ]
    },
    { name:     "SLOT0_PTR_OUT_C3",
      desc:     "Slot 1 output data pointer for fourth column used",
      swaccess: "rw",
      hwaccess: "hro",
      fields: [
        { bits: "31:0", name: "SLOT0_PTR_OUT_C3", desc: "Slot 0 output data pointer for fourth column used" }
      ]
    },

    { name:     "SLOT1_PTR_IN_C0",
      desc:     "Slot 1 input data pointer for first column used",
      swaccess: "rw",
      hwaccess: "hro",
      fields: [
        { bits: "31:0", name: "SLOT1_PTR_IN_C0", desc: "Slot 1 input data pointer for first column used" }
      ]
    },
    { name:     "SLOT1_PTR_OUT_C0",
      desc:     "Slot 1 output data pointer for first column used",
      swaccess: "rw",
      hwaccess: "hro",
      fields: [
        { bits: "31:0", name: "SLOT1_PTR_OUT_C0", desc: "Slot 1 output data pointer for first column used" }
      ]
    },
    { name:     "SLOT1_PTR_IN_C1",
      desc:     "Slot 1 input data pointer for second column used",
      swaccess: "rw",
      hwaccess: "hro",
      fields: [
        { bits: "31:0", name: "SLOT1_PTR_IN_C1", desc: "Slot 1 input data pointer for second column used" }
      ]
    },
    { name:     "SLOT1_PTR_OUT_C1",
      desc:     "Slot 1 Output data pointer for second column used",
      swaccess: "rw",
      hwaccess: "hro",
      fields: [
        { bits: "31:0", name: "SLOT1_PTR_OUT_C1", desc: "Slot 1 Output data pointer for second column used" }
      ]
    },
    { name:     "SLOT1_PTR_IN_C2",
      desc:     "Slot 1 input data pointer for third column used",
      swaccess: "rw",
      hwaccess: "hro",
      fields: [
        { bits: "31:0", name: "SLOT1_PTR_IN_C2", desc: "Slot 1 input data pointer for third column used" }
      ]
    },
    { name:     "SLOT1_PTR_OUT_C2",
      desc:     "Slot 1 output data pointer for first column used",
      swaccess: "rw",
      hwaccess: "hro",
      fields: [
        { bits: "31:0", name: "SLOT1_PTR_OUT_C2", desc: "Slot 1 output data pointer for first column used" }
      ]
    },
    { name:     "SLOT1_PTR_IN_C3",
      desc:     "Slot 1 input data pointer for fourth column used",
      swaccess: "rw",
      hwaccess: "hro",
      fields: [
        { bits: "31:0", name: "SLOT1_PTR_IN_C3", desc: "Slot 1 input data pointer for fourth column used" }
      ]
    },
    { name:     "SLOT1_PTR_OUT_C3",
      desc:     "Slot 1 output data pointer for fourth column used",
      swaccess: "rw",
      hwaccess: "hro",
      fields: [
        { bits: "31:0", name: "SLOT1_PTR_OUT_C3", desc: "Slot 1 output data pointer for fourth column used" }
      ]
    },
    { name:     "PERF_CNT_ENABLE",
      desc:     "Enable performance counters",
      swaccess: "rw",
      hwaccess: "hro",
      fields: [
        { bits: "31:0", name: "COL_STATUS", desc: "Enable performance counters" }
      ]
    },
    { name:     "RESERVED19",
      desc:     "Reserved",
      swaccess: "rw",
      hwaccess: "hro",
      fields: [
        { bits: "31:0", name: "RESERVED19", desc: "Reserved" }
      ]
    },
    { name:     "RESERVED20",
      desc:     "Reserved",
      swaccess: "rw",
      hwaccess: "hro",
      fields: [
        { bits: "31:0", name: "RESERVED20", desc: "Reserved" }
      ]
    },
    { name:     "RESERVED21",
      desc:     "Reserved",
      swaccess: "rw",
      hwaccess: "hro",
      fields: [
        { bits: "31:0", name: "RESERVED21", desc: "Reserved" }
      ]
    },
    { name:     "RESERVED22",
      desc:     "Reserved",
      swaccess: "rw",
      hwaccess: "hro",
      fields: [
        { bits: "31:0", name: "RESERVED22", desc: "Reserved" }
      ]
    },
    { name:     "RESERVED23",
      desc:     "Reserved",
      swaccess: "rw",
      hwaccess: "hro",
      fields: [
        { bits: "31:0", name: "RESERVED23", desc: "Reserved" }
      ]
    },
    { name:     "RESERVED24",
      desc:     "Reserved",
      swaccess: "rw",
      hwaccess: "hro",
      fields: [
        { bits: "31:0", name: "RESERVED24", desc: "Reserved" }
      ]
    },
    { name:     "RESERVED25",
      desc:     "Reserved",
      swaccess: "rw",
      hwaccess: "hro",
      fields: [
        { bits: "31:0", name: "RESERVED25", desc: "Reserved" }
      ]
    },
    { name:     "RESERVED26",
      desc:     "Reserved",
      swaccess: "rw",
      hwaccess: "hro",
      fields: [
        { bits: "31:0", name: "RESERVED26", desc: "Reserved" }
      ]
    },
    { name:     "RESERVED27",
      desc:     "Reserved",
      swaccess: "rw",
      hwaccess: "hro",
      fields: [
        { bits: "31:0", name: "RESERVED27", desc: "Reserved" }
      ]
    },
    { name:     "RESERVED28",
      desc:     "Reserved",
      swaccess: "rw",
      hwaccess: "hro",
      fields: [
        { bits: "31:0", name: "RESERVED28", desc: "Reserved" }
      ]
    },
    { name:     "RESERVED29",
      desc:     "Reserved",
      swaccess: "rw",
      hwaccess: "hro",
      fields: [
        { bits: "31:0", name: "RESERVED29", desc: "Reserved" }
      ]
    },
    { name:     "RESERVED30",
      desc:     "Reserved",
      swaccess: "rw",
      hwaccess: "hro",
      fields: [
        { bits: "31:0", name: "RESERVED30", desc: "Reserved" }
      ]
    },
   ]
}
